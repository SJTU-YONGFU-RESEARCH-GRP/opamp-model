* Op-amp noise analysis stub (Phase 3).
* Validates ngspice batch run; noise spectrum/metrics come from the Python golden.

.title noise_stub

VDD vdd 0 DC 1.8
VSS vss 0 DC 0
Rout out 0 100
Vout out 0 DC 0

.op

.end
