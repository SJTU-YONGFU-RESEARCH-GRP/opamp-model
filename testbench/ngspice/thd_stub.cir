* Op-amp THD TRAN stub.
* Validates ngspice batch run; waveform/THD metrics come from the Python golden.

.title thd_stub

VDD vdd 0 DC 1.8
VSS vss 0 DC 0
Rout out 0 100
Vout out 0 DC 0

.op

.end
