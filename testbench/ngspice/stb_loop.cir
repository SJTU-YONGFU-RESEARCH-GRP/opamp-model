* Loop-gain AC — same one-pole open-loop macromodel as ac_open_loop.cir.
* run_stb.py applies loop_beta to gain (dB) after simulation (same as Spectre STB flow).

.param a0_db=80
.param gbw_hz=10Meg
.param rin_ohm=1e12
.param rout_ohm=100
.param a0_linear=PLACEHOLDER_A0
.param wp_rad_s=PLACEHOLDER_WP
.param rlp_ohm=PLACEHOLDER_RLP
.param clp_f=PLACEHOLDER_CLP

VDD vdd 0 DC 1.8
VSS vss 0 DC 0
VCM inn 0 DC 0.9
Rinn inn 0 {rin_ohm}
Rinp inp 0 {rin_ohm}
VAC inp 0 DC 0.9 AC 1

Eaux n1 0 inp inn {a0_linear}
Rlp n1 n2 {rlp_ohm}
Clp n2 0 {clp_f}
Eout out 0 n2 0 1
ROUT out 0 {rout_ohm}

.ac dec 10 1 100Meg
.control
run
set wr_singlescale
wrdata stb_bode.raw frequency vdb(out) vp(out)
.endc

.end
