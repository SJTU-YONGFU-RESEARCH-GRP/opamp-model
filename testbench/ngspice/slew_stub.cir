* Op-amp slew-rate TRAN stub.
* Validates ngspice batch run; step response/metrics come from the Python golden.

.title slew_stub

VDD vdd 0 DC 1.8
VSS vss 0 DC 0
Rout out 0 100
Vout out 0 DC 0

.op

.end
