* Open-loop AC Bode — ngspice RC-pole + VCVS macromodel.
* Run via: python scripts/run_ac.py --ngspice --output-dir outputs/ngspice

.param a0_db=80
.param gbw_hz=10Meg
.param rin_ohm=1e12
.param rout_ohm=100
.param a0_linear=PLACEHOLDER_A0
.param rlp_ohm=1000
.param clp_f=PLACEHOLDER_CLP

VDD vdd 0 DC 1.8
VSS vss 0 DC 0
VCM inn 0 DC 0.9
Rinn inn 0 {rin_ohm}
Rinp inp 0 {rin_ohm}
VAC inp 0 DC 0.9 AC 1

Eaux n1 0 inp inn PLACEHOLDER_A0
Rlp n1 n2 {rlp_ohm}
Clp n2 0 {clp_f}
Rbias n2 0 1e9
Eout out 0 n2 0 1
ROUT out 0 {rout_ohm}

.ac dec 10 1 100Meg
.control
run
set wr_singlescale
wrdata ac_bode.raw frequency vdb(out) vp(out)
.endc

.end
