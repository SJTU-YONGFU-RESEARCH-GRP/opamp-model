* Open-loop AC Bode — ngspice macromodel (laplace_nd equivalent).
*
* Target (same as core.py / configurable_opamp.va):
*   H(s) = A0 / (1 + s/wp) / (1 + s/wp2) * (1 + s/wz)
*   wp = 2*pi*GBW_HZ / A0_LINEAR;  wp2 = 2*pi*FP2_HZ;  wz = 2*pi*FZ_HZ
* Spectre laplace_nd form:
*   numer = {A0*wp, 0},  denom = {wp, 1}  =>  V = (A0*wp*vd) / (s + wp)
*
* ngspice realization (ideal VCVS + dominant-pole RC + optional fp2/fz):
*   V(n1) = A0 * (V(inp) - V(inn))
*   V(n2) = V(n1) / (1 + s*Rlp*Clp),  Rlp*Clp = 1/wp
*   Optional second pole: Rfp2*Cfp2 = 1/wp2
*   Optional zero: B-source laplace (1 + s/wz)
*   V(out) = V(n4)
* When fp2_hz=0 and fz_hz=0, optional stages are bypassed (one-pole default).

.param a0_db=80
.param gbw_hz=10Meg
.param fp2_hz=0
.param fz_hz=0
.param rin_ohm=1e12
.param rout_ohm=100
.param a0_linear=PLACEHOLDER_A0
.param wp_rad_s=PLACEHOLDER_WP
.param rlp_ohm=PLACEHOLDER_RLP
.param clp_f=PLACEHOLDER_CLP

VDD vdd 0 DC 1.8
VSS vss 0 DC 0
VCM inn 0 DC 0.9
Rinn inn 0 {rin_ohm}
Rinp inp 0 {rin_ohm}
VAC inp 0 DC 0.9 AC 1

Eaux n1 0 inp inn {a0_linear}
Rlp n1 n2 {rlp_ohm}
Clp n2 0 {clp_f}
PLACEHOLDER_FP2_BLOCK
PLACEHOLDER_FZ_BLOCK
Eout out 0 PLACEHOLDER_OUT_NODE 0 1
ROUT out 0 {rout_ohm}

.ac dec 10 1 100Meg
.control
run
set wr_singlescale
wrdata ac_bode.raw frequency vdb(out) vp(out)
.endc

.end
