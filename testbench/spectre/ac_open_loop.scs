// Open-loop AC Bode testbench (Cadence Spectre).
//
// Run via:
//   python scripts/run_ac.py --spectre --output-dir outputs/spectre

simulator lang=spectre

include "./testbench/spectre/opamp_include.scs"

parameters a0_db=80
parameters gbw_hz=10Meg
parameters cmrr_db=90
parameters psrr_db=80
parameters psrr_pole_hz=100
parameters rin_ohm=1T
parameters cin_f=1p
parameters rout_ohm=100
parameters cout_f=2p
parameters f_start=1
parameters f_stop=100Meg
parameters dec=10

VDD (vdd 0) vsource dc=1.8
VSS (vss 0) vsource dc=0.0
VCM (inn 0) vsource dc=0.9 type=dc

VAC (inp 0) vsource dc=0.9 type=dc mag=1 phase=0

XOP (inp inn out vdd vss) configurable_opamp \
    A0_DB=a0_db GBW_HZ=gbw_hz CMRR_DB=cmrr_db PSRR_DB=psrr_db \
    PSRR_POLE_HZ=psrr_pole_hz RIN_OHM=rin_ohm CIN_F=cin_f ROUT_OHM=rout_ohm COUT_F=cout_f

ROUT (out 0) resistor r=rout_ohm
COUT (out 0) capacitor c=cout_f

save out
ac ac start=f_start stop=f_stop dec=dec annotate=status
