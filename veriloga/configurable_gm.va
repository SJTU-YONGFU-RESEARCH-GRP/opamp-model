// Transconductance (Gm / OTA) macromodel.
// Iout = GM_S * (V(inp) - V(inn)); load Rout||Cout externally in the netlist.

`include "constants.vams"
`include "disciplines.vams"

(* compact_module *)
(* instance_parameter_list = {GM_S, ROUT_OHM, COUT_F} *)
module configurable_gm(inp, inn, iout, vdd, vss);

    input inp, inn, vdd, vss;
    electrical inp, inn, vdd, vss;
    output iout;
    electrical iout;

    parameter real GM_S = 1.0e-3;
    parameter real ROUT_OHM = 1.0e6;
    parameter real COUT_F = 500.0e-15;
    parameter integer NOISE_SEED = 1;

    analog begin
        I(iout) <+ GM_S * V(inp, inn);
    end

endmodule
