// Configurable voltage op-amp — dominant-pole differential macromodel.
//
// Open-loop: H(s) = A0 / (1 + s/wp) / (1 + s/wp2) * (1 + s/wz)
//   wp = 2*pi*GBW_HZ/A0_LINEAR;  wp2 = 2*pi*FP2_HZ;  wz = 2*pi*FZ_HZ
// When FP2_HZ=0 and FZ_HZ=0, only the dominant pole is applied.
// CMRR: ACM(s) = Aol(s) / CMRR_LINEAR  (common-mode path)
// PSRR: H_ps(s) = (1/PSRR_LINEAR) / (1 + s/wp_psrr)  (VDD feedthrough)
// Noise: thermal on n_noi via I=V/R (Spectre auto thermal noise), flicker on n_noi,
// shaped by the same laplace_nd chain as the differential signal.
//
// Spectre notes:
// - laplace_nd coeffs must be refreshed each analog evaluation (not only initial_step).
// - Pass V(inp)-V(inn) directly into laplace_nd (not via intermediate reals).
// - Model Rout||Cout with external netlist passives; internal I(out) shunts break AC.

`include "constants.vams"
`include "disciplines.vams"

(* instance_parameter_list = {A0_DB, GBW_HZ, FP2_HZ, FZ_HZ, CMRR_DB, PSRR_DB, PSRR_POLE_HZ,
    RIN_OHM, CIN_F, ROUT_OHM, COUT_F, EN_WHITE_V_PER_SQRT_HZ,
    EN_FLICKER_1HZ_V_PER_SQRT_HZ, EN_FLICKER_EF, KF, AF, BIAS_CURRENT_A,
    ENABLE_NOISE} *)
module configurable_opamp(inp, inn, out, vdd, vss);

    input inp, inn, vdd, vss;
    electrical inp, inn, vdd, vss;
    output out;
    electrical out;
    // Isolated node for input-referred noise (Spectre .noise through laplace_nd).
    electrical n_noi;

    parameter real A0_DB = 80.0;
    parameter real GBW_HZ = 10.0e6;
    parameter real FP2_HZ = 0.0;
    parameter real FZ_HZ = 0.0;
    parameter real CMRR_DB = 90.0;
    parameter real PSRR_DB = 80.0;
    parameter real PSRR_POLE_HZ = 100.0;
    parameter real RIN_OHM = 1.0e12;
    parameter real CIN_F = 1.0e-12;
    parameter real ROUT_OHM = 100.0;
    parameter real COUT_F = 2.0e-12;
    parameter real EN_WHITE_V_PER_SQRT_HZ = 0.0;
    parameter real EN_FLICKER_1HZ_V_PER_SQRT_HZ = 0.0;
    parameter real EN_FLICKER_EF = 1.0;
    parameter real KF = 0.0;
    parameter real AF = 1.0;
    parameter real BIAS_CURRENT_A = 1.0e-6;
    parameter real ENABLE_NOISE = 0.0;

    real a0_linear;
    real cmrr_linear;
    real psrr_linear;
    real wp;
    real wp2;
    real wz;
    real wp_psrr;
    real rn_noise;
    real pn_flicker;
    real ir_bias;
    real v_diff;
    real v_cm;
    // Spectre laplace_nd requires array variables (not inline parameter expressions).
    real numer[0:1];
    real denom[0:1];
    real fp2_numer[0:1];
    real fp2_denom[0:1];
    real fz_numer[0:1];
    real fz_denom[0:1];
    real cm_numer[0:1];
    real cm_denom[0:1];
    real ps_numer[0:1];
    real ps_denom[0:1];

    analog begin
        a0_linear = pow(10.0, A0_DB / 20.0);
        if (a0_linear < 1.0)
            a0_linear = 1.0;
        cmrr_linear = pow(10.0, CMRR_DB / 20.0);
        if (cmrr_linear < 1.0)
            cmrr_linear = 1.0;
        psrr_linear = pow(10.0, PSRR_DB / 20.0);
        if (psrr_linear < 1.0)
            psrr_linear = 1.0;
        wp = 2.0 * `M_PI * GBW_HZ / a0_linear;
        wp_psrr = 2.0 * `M_PI * PSRR_POLE_HZ;
        if (wp_psrr < 1.0e-30)
            wp_psrr = 1.0e-30;
        // H(s) = (a0*wp) / (s + wp)  <=>  numer {a0*wp, 0}, denom {wp, 1}
        numer[0] = a0_linear * wp;
        numer[1] = 0.0;
        denom[0] = wp;
        denom[1] = 1.0;
        // ACM(s) = Aol(s) / CMRR_LINEAR
        cm_numer[0] = numer[0] / cmrr_linear;
        cm_numer[1] = 0.0;
        cm_denom[0] = wp;
        cm_denom[1] = 1.0;
        // H_ps(s) = (1/psrr_linear) / (1 + s/wp_psrr)
        ps_numer[0] = (1.0 / psrr_linear) * wp_psrr;
        ps_numer[1] = 0.0;
        ps_denom[0] = wp_psrr;
        ps_denom[1] = 1.0;

        // Differential open-loop path with optional second pole and zero.
        // V(n_noi) adds input-referred thermal/flicker inside laplace_nd so Spectre
        // .noise propagates noise through the same filter as the AC signal path.
        v_diff = laplace_nd(V(inp) - V(inn) + V(n_noi), numer, denom);
        if (FP2_HZ > 0.0)
            wp2 = 2.0 * `M_PI * FP2_HZ;
        else
            wp2 = 1.0e30;
        fp2_numer[0] = wp2;
        fp2_numer[1] = 0.0;
        fp2_denom[0] = wp2;
        fp2_denom[1] = 1.0;
        v_diff = laplace_nd(v_diff, fp2_numer, fp2_denom);
        if (FZ_HZ > 0.0)
            wz = 2.0 * `M_PI * FZ_HZ;
        else
            wz = 1.0e30;
        fz_numer[0] = wz;
        fz_numer[1] = 1.0;
        fz_denom[0] = wz;
        fz_denom[1] = 0.0;
        v_diff = laplace_nd(v_diff, fz_numer, fz_denom);

        // Common-mode path: ACM(s) = Aol(s) / CMRR_LINEAR (same fp2/fz shaping).
        v_cm = laplace_nd(0.5 * (V(inp) + V(inn)), cm_numer, cm_denom);
        fp2_numer[0] = wp2;
        fp2_numer[1] = 0.0;
        fp2_denom[0] = wp2;
        fp2_denom[1] = 1.0;
        v_cm = laplace_nd(v_cm, fp2_numer, fp2_denom);
        fz_numer[0] = wz;
        fz_numer[1] = 1.0;
        fz_denom[0] = wz;
        fz_denom[1] = 0.0;
        v_cm = laplace_nd(v_cm, fz_numer, fz_denom);

        // Input-referred thermal noise: resistive branch on n_noi (Spectre adds thermal
        // noise to I = V/R automatically). Flicker uses explicit flicker_noise.
        if (ENABLE_NOISE != 0.0) begin
            rn_noise = 1.0e-30;
            if (EN_WHITE_V_PER_SQRT_HZ > 0.0) begin
                rn_noise = (EN_WHITE_V_PER_SQRT_HZ * EN_WHITE_V_PER_SQRT_HZ)
                         / (4.0 * `P_K * $temperature);
                if (rn_noise < 1.0e-30)
                    rn_noise = 1.0e-30;
                I(n_noi, vss) <+ V(n_noi, vss) / rn_noise;
            end
            pn_flicker = 0.0;
            if (EN_FLICKER_1HZ_V_PER_SQRT_HZ > 0.0) begin
                pn_flicker = EN_FLICKER_1HZ_V_PER_SQRT_HZ
                           * EN_FLICKER_1HZ_V_PER_SQRT_HZ;
                if (RIN_OHM > 0.0)
                    I(n_noi, vss) <+ flicker_noise(pn_flicker / (RIN_OHM * RIN_OHM),
                                                    EN_FLICKER_EF, "flicker");
            end else if (KF > 0.0 && abs(BIAS_CURRENT_A) > 0.0) begin
                pn_flicker = KF * pow(abs(BIAS_CURRENT_A), AF);
                ir_bias = BIAS_CURRENT_A;
                if (ir_bias >= 0.0)
                    I(n_noi, vss) <+ flicker_noise(pn_flicker, EN_FLICKER_EF, "flicker");
                else
                    I(n_noi, vss) <+ flicker_noise(-pn_flicker, EN_FLICKER_EF, "flicker");
            end
        end
        // Pass branch potentials directly into laplace_nd; assigning to reals
        // first strips Spectre AC small-signal and yields zero gain in PSF.
        V(out) <+ v_diff + v_cm + laplace_nd(V(vdd), ps_numer, ps_denom);

        // High-Z differential input conductance (optional loading).
        if (RIN_OHM > 0.0)
            I(inp, inn) <+ V(inp, inn) / RIN_OHM;
        if (CIN_F > 0.0)
            I(inp, inn) <+ CIN_F * ddt(V(inp, inn));

        // Output shunt (Rout || Cout) — modeled externally in Spectre/SPICE netlists;
        // an internal I(out) shunt here breaks Spectre AC with laplace_nd.
    end

endmodule
